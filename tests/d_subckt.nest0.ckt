spice

* this works as expected
.subckt m0 a b c d
.ends

.subckt m1 a b c d
X1 a b c d m0
.ends

* and this does not
.subckt m2 a b c d
	.subckt m3 a b c d
	.ends

	.subckt m4 a b c d
	X2 a b c d m3
	.ends
	X4 a b c d m4
.ends

X0 a b c d m2

.dc
.list
